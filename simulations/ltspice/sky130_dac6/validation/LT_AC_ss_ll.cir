LTspice buffer AC matrix ss RC ll
.include models/buffer_ss_ll.lib
.include ../Sky130_Adapters.lib
.include buffer_circuit.lib
.func PDK_GAUSS(s) {gauss(s)}
.param CASE=1
.param TEMP_C=table(CASE,1,-40,2,-40,3,-40,4,25,5,25,6,25,7,110,8,110,9,110)
.param AVDD=table(CASE,1,3.135,2,3.135,3,3.135,4,3.135,5,3.135,6,3.135,7,3.135,8,3.135,9,3.135)
.param IREF=table(CASE,1,8e-07,2,8e-07,3,8e-07,4,8e-07,5,8e-07,6,8e-07,7,8e-07,8,8e-07,9,8e-07)
.param VIN_DC=table(CASE,1,0.3,2,1.65,3,2.9578125,4,0.3,5,1.65,6,2.9578125,7,0.3,8,1.65,9,2.9578125)
.param CLOAD=table(CASE,1,2e-11,2,2e-11,3,2e-11,4,2e-11,5,2e-11,6,2e-11,7,2e-11,8,2e-11,9,2e-11)
.param PDK_TEMP={TEMP_C}
.temp {TEMP_C}
VDD VDD 0 {AVDD}
IB VDD IBIAS {IREF}
VIN VIN 0 {VIN_DC}
VTEST FB OUT 0 AC 1
XBUF VIN FB VDD 0 IBIAS OUT Sky_OTA
RL OUT 0 100k
CL OUT 0 {CLOAD}
.nodeset V(OUT)={VIN_DC} V(FB)={VIN_DC}
.step param CASE 1 9 1
.ac dec 60 1 100Meg
.save V(OUT) V(FB)
.meas ac T_USED PARAM TEMP_C
.meas ac INPUT_USED PARAM VIN_DC
.options solver=alt plotwinsize=0 reltol=1e-4 abstol=1e-14 vntol=1e-7 gmin=1e-14 itl1=500
.end
