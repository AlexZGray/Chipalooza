LTspice buffer AC matrix ff RC nominal
.include models/buffer_ff.lib
.include ../Sky130_Adapters.lib
.include buffer_circuit.lib
.func PDK_GAUSS(s) {gauss(s)}
.param CASE=1
.param TEMP_C=table(CASE,1,-40,2,-40,3,-40,4,-40,5,-40,6,-40,7,-40,8,-40,9,-40,10,-40,11,-40,12,-40,13,-40,14,-40,15,-40,16,-40,17,-40,18,-40,19,-40,20,-40,21,-40,22,-40,23,-40,24,-40,25,25,26,25,27,25,28,25,29,25,30,25,31,25,32,25,33,25,34,25,35,25,36,25,37,25,38,25,39,25,40,25,41,25,42,25,43,25,44,25,45,25,46,25,47,25,48,25,49,110,50,110,51,110,52,110,53,110,54,110,55,110,56,110,57,110,58,110,59,110,60,110,61,110,62,110,63,110,64,110,65,110,66,110,67,110,68,110,69,110,70,110,71,110,72,110)
.param AVDD=table(CASE,1,3.135,2,3.135,3,3.135,4,3.135,5,3.135,6,3.135,7,3.135,8,3.135,9,3.135,10,3.135,11,3.135,12,3.135,13,3.465,14,3.465,15,3.465,16,3.465,17,3.465,18,3.465,19,3.465,20,3.465,21,3.465,22,3.465,23,3.465,24,3.465,25,3.135,26,3.135,27,3.135,28,3.135,29,3.135,30,3.135,31,3.135,32,3.135,33,3.135,34,3.135,35,3.135,36,3.135,37,3.465,38,3.465,39,3.465,40,3.465,41,3.465,42,3.465,43,3.465,44,3.465,45,3.465,46,3.465,47,3.465,48,3.465,49,3.135,50,3.135,51,3.135,52,3.135,53,3.135,54,3.135,55,3.135,56,3.135,57,3.135,58,3.135,59,3.135,60,3.135,61,3.465,62,3.465,63,3.465,64,3.465,65,3.465,66,3.465,67,3.465,68,3.465,69,3.465,70,3.465,71,3.465,72,3.465)
.param IREF=table(CASE,1,8e-07,2,8e-07,3,8e-07,4,8e-07,5,8e-07,6,8e-07,7,1.2e-06,8,1.2e-06,9,1.2e-06,10,1.2e-06,11,1.2e-06,12,1.2e-06,13,8e-07,14,8e-07,15,8e-07,16,8e-07,17,8e-07,18,8e-07,19,1.2e-06,20,1.2e-06,21,1.2e-06,22,1.2e-06,23,1.2e-06,24,1.2e-06,25,8e-07,26,8e-07,27,8e-07,28,8e-07,29,8e-07,30,8e-07,31,1.2e-06,32,1.2e-06,33,1.2e-06,34,1.2e-06,35,1.2e-06,36,1.2e-06,37,8e-07,38,8e-07,39,8e-07,40,8e-07,41,8e-07,42,8e-07,43,1.2e-06,44,1.2e-06,45,1.2e-06,46,1.2e-06,47,1.2e-06,48,1.2e-06,49,8e-07,50,8e-07,51,8e-07,52,8e-07,53,8e-07,54,8e-07,55,1.2e-06,56,1.2e-06,57,1.2e-06,58,1.2e-06,59,1.2e-06,60,1.2e-06,61,8e-07,62,8e-07,63,8e-07,64,8e-07,65,8e-07,66,8e-07,67,1.2e-06,68,1.2e-06,69,1.2e-06,70,1.2e-06,71,1.2e-06,72,1.2e-06)
.param VIN_DC=table(CASE,1,0.3,2,0.3,3,1.65,4,1.65,5,2.9578125,6,2.9578125,7,0.3,8,0.3,9,1.65,10,1.65,11,2.9578125,12,2.9578125,13,0.3,14,0.3,15,1.65,16,1.65,17,2.9578125,18,2.9578125,19,0.3,20,0.3,21,1.65,22,1.65,23,2.9578125,24,2.9578125,25,0.3,26,0.3,27,1.65,28,1.65,29,2.9578125,30,2.9578125,31,0.3,32,0.3,33,1.65,34,1.65,35,2.9578125,36,2.9578125,37,0.3,38,0.3,39,1.65,40,1.65,41,2.9578125,42,2.9578125,43,0.3,44,0.3,45,1.65,46,1.65,47,2.9578125,48,2.9578125,49,0.3,50,0.3,51,1.65,52,1.65,53,2.9578125,54,2.9578125,55,0.3,56,0.3,57,1.65,58,1.65,59,2.9578125,60,2.9578125,61,0.3,62,0.3,63,1.65,64,1.65,65,2.9578125,66,2.9578125,67,0.3,68,0.3,69,1.65,70,1.65,71,2.9578125,72,2.9578125)
.param CLOAD=table(CASE,1,0,2,2e-11,3,0,4,2e-11,5,0,6,2e-11,7,0,8,2e-11,9,0,10,2e-11,11,0,12,2e-11,13,0,14,2e-11,15,0,16,2e-11,17,0,18,2e-11,19,0,20,2e-11,21,0,22,2e-11,23,0,24,2e-11,25,0,26,2e-11,27,0,28,2e-11,29,0,30,2e-11,31,0,32,2e-11,33,0,34,2e-11,35,0,36,2e-11,37,0,38,2e-11,39,0,40,2e-11,41,0,42,2e-11,43,0,44,2e-11,45,0,46,2e-11,47,0,48,2e-11,49,0,50,2e-11,51,0,52,2e-11,53,0,54,2e-11,55,0,56,2e-11,57,0,58,2e-11,59,0,60,2e-11,61,0,62,2e-11,63,0,64,2e-11,65,0,66,2e-11,67,0,68,2e-11,69,0,70,2e-11,71,0,72,2e-11)
.param PDK_TEMP={TEMP_C}
.temp {TEMP_C}
VDD VDD 0 {AVDD}
IB VDD IBIAS {IREF}
VIN VIN 0 {VIN_DC}
VTEST FB OUT 0 AC 1
XBUF VIN FB VDD 0 IBIAS OUT Sky_OTA
RL OUT 0 100k
CL OUT 0 {CLOAD}
.nodeset V(OUT)={VIN_DC} V(FB)={VIN_DC}
.step param CASE 1 72 1
.ac dec 60 1 100Meg
.save V(OUT) V(FB)
.meas ac T_USED PARAM TEMP_C
.meas ac INPUT_USED PARAM VIN_DC
.options solver=alt plotwinsize=0 reltol=1e-4 abstol=1e-14 vntol=1e-7 gmin=1e-14 itl1=500
.end
